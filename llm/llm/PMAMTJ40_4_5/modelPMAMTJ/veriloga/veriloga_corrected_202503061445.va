verilog
`resetall
`include "constants.vams"
`include "disciplines.vams"
`define explimit 85.0
`define exp(x) exp(min(max((x),-`explimit),`explimit))
`define sqrt(x) pow( (x), 0.5)

//Shape definition
`define rec 1
`define ellip 2
`define circle 3

module Model(T1, T2, Ttrans, Temp, Duration);
    output Duration;
    electrical Duration;
    inout T1, T2;
    electrical T1, T2;
    electrical n1, n2; //virtual terminals of RC circuit for time modelisation for temperature

    inout Ttrans, Temp;
    electrical Ttrans, Temp;

    parameter real alpha = 0.027;
    parameter real gamma = 1.76e7;
    parameter real P = 0.52;
    parameter real Hk = 1433;
    parameter real Ms = 15800;
    parameter real PhiBas = 0.4;
    parameter real Vh = 0.5;

    parameter real tsl = 1.3e-9 from[0.7e-9:3.0e-9];
    parameter real a = 40e-9;
    parameter real b = 40e-9;
    parameter real r = 20e-9;
    parameter real tox = 8.5e-10 from[8e-10:15e-10];
    parameter real TMR = 0.7;

    parameter real SHAPE = 2 from[1:3];

    parameter real tau0 = 8.7e-10;
    parameter real Ps = 0.999999;
    parameter real brown_threshold = 0.0;

    parameter integer PAP = 1 from[0:1];
    parameter real T = 300;

    parameter real RA = 5 from[5:15];

    parameter real Cv = 2.74e6 from[2.735e6:2.7805e6];
    parameter real lam = 84.897 from[84.8912:84.9449];

    parameter real thick_s = 3.355e-8;
    parameter real resistor = 100e6;
    parameter real coeff_tau = 12;

    real capacitor;
    real tau_th;
    real temp;
    real temp_init;
    real R;

    parameter integer STO = 0 from[0:2];
    parameter integer RV = 0 from[0:2];
    parameter integer Temp_var = 0 from[0:1];

    parameter real DEV_tox = 0.03;
    parameter real DEV_tsl = 0.03;
    parameter real DEV_TMR = 0.03;

    parameter real STO_dev = 0.03;

    real PolaP;
    real PolaAP;
    real surface;
    real gp;
    real gap;
    real Em, EE;
    real TMRR;
    real Ro, Rap, Rp;
    real Vb, Vc;
    real Id;
    real IcAP, IcP;
    real ix;
    real tau;
    real FA;
    integer seed;
    real durationstatic, duration;
    real toxreal, tslreal, TMRreal;
    parameter real seedin = 0;

    real P_APt;
    real AP_Pt;
    real NP_APt, NAP_Pt;

    analog begin
        if (SHAPE == 1) begin
            surface = a * b;
        end else if (SHAPE == 2) begin
            surface = `M_PI * a * b / 4;
        end else begin
            surface = `M_PI * r * r;
        end

        Vc = V(T2, T1);
        Vb = V(T1, T2);

        @(initial_step) begin
            seed = 1000000000 * seedin;
            FA = 3322.53 / csv;

            if (RV == 1) begin
                toxreal = $rdist_uniform(seed, (tox - tox * DEV_tox), (tox + tox * DEV_tox));
                tslreal = $rdist_uniform(seed, (tsl - tsl * DEV_tsl), (tsl + tsl * DEV_tsl));
                TMRreal = $rdist_uniform(seed, (TMR - TMR * DEV_TMR), (TMR + TMR * DEV_TMR));
            end else if (RV == 2) begin
                toxreal = abs($rdist_normal(seed, tox, tox * DEV_tox / 3));
                tslreal = abs($rdist_normal(seed, tsl, tsl * DEV_tsl / 3));
                TMRreal = abs($rdist_normal(seed, TMR, TMR * DEV_TMR / 3));
            end else begin
                toxreal = tox;
                tslreal = tsl;
                TMRreal = TMR;
            end

            temp = T;
            temp_init = T;
            tau_th = Cv * thick_s / (lam / thick_s);
            capacitor = coeff_tau * tau_th / resistor;
            Ro = (toxreal * 1.0e10 / (FA * `sqrt(PhiBas) * surface * 1.0e12)) * `exp(1.025 * toxreal * 1.0e10 * `sqrt(PhiBas));
            Em = Ms * tslreal * surface * Hk / 2;
            duration = 0.0;
            P_APt = 1000000000;
            AP_Pt = 1000000000;
            NP_APt = 1000000000;
            NAP_Pt = 1000000000;
            if (analysis("dc")) begin
                ix = PAP;
            end else begin
                ix = -PAP;
            end
        end

        if (Temp_var == 0) begin
            temp = temp_init;
        end else begin
            temp = V(Temp);
        end

        EE = Em / (`Kb * temp * 40 * `M_PI);
        TMRR = TMRreal / (1 + Vb + Vb / (Vh * Vh));
        Rp = Ro;
        Rap = Rp * (1 + TMRR);
        if (ix == 0) begin
            R = Rp;
        end else begin
            R = Rap;
        end
        Id = Vb / R;

        PolaP = `sqrt(TMRreal * (TMRreal + 2)) / (2 * (TMRreal + 1));
        gp = alpha * gamma * `e * Ms * tslreal * Hk / (40 * `M_PI * (`ub * PolaP));
        IcP = gp * surface;

        PolaAP = `sqrt(TMRreal * (TMRreal + 2)) / (2 * (TMRreal + 1));
        gap = alpha * gamma * `e * Ms * tslreal * Hk / (40 * `M_PI * (`ub * PolaAP));
        IcAP = gap * surface;

        @(above(Id - IcP, +1)) begin
            P_APt = $abstime;
            NP_APt = 1000000000;
        end

        @(above(-Id - IcAP, +1)) begin
            AP_Pt = $abstime;
            NAP_Pt = 1000000000;
        end

        @(above(Vb - brown_threshold, +1)) begin
            NP_APt = $abstime;
            AP_Pt = 1000000000;
            NAP_Pt = 1000000000;
        end

        @(above(Vc - brown_threshold, +1)) begin
            NAP_Pt = $abstime;
            P_APt = 1000000000;
            NP_APt = 1000000000;
        end

        if (analysis("dc")) begin
            if (ix == 0) begin
                if (Vb >= (IcP * Rp)) begin
                    ix = 1.0;
                end
            end else begin
                if (Vc >= (IcAP * Rap)) begin
                    ix = 0.0;
                end
            end

            V(Ttrans) <+ ix;
            I(T1, T2) <+ Id;
        end else begin
            if (STO == 1 || STO == 2) begin
                if (ix == 0) begin
                    if (Vb >= IcP * Rp) begin
                        durationstatic = (`C + ln(`M_PI * `M_PI * (Em / (`Kb * temp * 40 * `M_PI)) / 4)) * `e * 1000 * Ms * surface * tslreal * (1 + P * P) / (4 * `M_PI * 2 * `ub * P * 10000 * abs(Id - IcP));
                        if (STO == 1) begin
                            duration = abs($rdist_exponential(seed, durationstatic));
                        end else if (STO == 2) begin
                            duration = abs($rdist_normal(seed, durationstatic, durationstatic * STO_dev / 3));
                        end else begin
                            duration = durationstatic;
                        end

                        if (duration <= ($abstime - P_APt)) begin
                            ix = -1.0;
                        end else begin
                            ix = 0.0;
                        end
                    end else begin
                        ix = 0.0;
                        tau = tau0 * exp(Em * (1 - abs(Id / IcP)) / (`Kb * temp * 40 * `M_PI));

                        if (Vb > brown_threshold) begin
                            if (Vb < 0.8 * IcP * Rp) begin
                                if (STO == 1) begin
                                    duration = abs($rdist_exponential(seed, tau));
                                end else if (STO == 2) begin
                                    duration = abs($rdist_normal(seed, tau, tau * STO_dev / 3));
                                end else begin
                                    duration = tau;
                                end

                                if (($abstime - NP_APt) >= duration) begin
                                    ix = -1.0;
                                end else begin
                                    ix = 0.0;
                                end
                            end
                        end
                    end
                end else begin
                    if (Vc >= IcAP * Rap) begin
                        durationstatic = (`C + ln(`M_PI * `M_PI * (Em / (`Kb * temp * 40 * `M_PI)) / 4)) * `e * 1000 * Ms * surface * tslreal * (1 + P * P) / (4 * `M_PI * 2 * `ub * P * 10000 * abs(-Id - IcAP));
                        if (STO == 1) begin
                            duration = abs($rdist_exponential(seed, durationstatic));
                        end else if (STO == 2) begin
                            duration = abs($rdist_normal(seed, durationstatic, durationstatic * STO_dev / 3.0));
                        end else begin
                            duration = durationstatic;
                        end

                        if (duration <= ($abstime - AP_Pt)) begin
                            ix = 0.0;
                        end else begin
                            ix = -1.0;
                        end
                    end else begin
                        tau = tau0 * exp(Em * (1 - abs(Id / IcAP)) / (`Kb * temp * 40 * `M_PI));

                        if (Vc > brown_threshold) begin
                            if (Vc < 0.8 * IcAP * Rap) begin
                                if (STO == 1) begin
                                    duration = abs($rdist_exponential(seed, tau));
                                end else if (STO == 2) begin
                                    duration = abs($rdist_normal(seed, tau, tau * STO_dev / 3));
                                end else begin
                                    duration = tau;
                                end

                                if (duration <= ($abstime - NAP_Pt)) begin
                                    ix = 0.0;
                                end else begin
                                    ix = -1.0;
                                end
                            end
                        end
                    end
                end
            end else begin
                if (ix == 0) begin
                    if (Vb >= IcP * Rp) begin
                        durationstatic = (`C + ln(`M_PI * `M_PI * (Em / (`Kb * temp * 40 * `M_PI)) / 4)) * `e * 1000 * Ms * surface * tslreal * (1 + P * P) / (4 * `M_PI * 2 * `ub * P * 10000 * abs(Id - IcP));
                        duration = durationstatic;
                        if (duration <= ($abstime - P_APt)) begin
                            ix = -1.0;
                        end else begin
                            ix = 0.0;
                        end
                    end else begin
                        tau = tau0 * exp(Em * (1 - abs(Id / IcP)) / (`Kb * temp * 40 * `M_PI));

                        if (Vb > brown_threshold) begin
                            if (Vb < 0.8 * IcP * Rp) begin
                                duration = tau;
                                if (($abstime - NP_APt) >= duration) begin
                                    ix = -1.0;
                                end else begin
                                    ix = 0.0;
                                end
                            end
                        end
                    end
                end else begin
                    if (Vc >= IcAP * Rap) begin
                        durationstatic = (`C + ln(`M_PI * `M_PI * (Em / (`Kb * temp * 40 * `M_PI)) / 4)) * `e * 1000 * Ms * surface * tslreal * (1 + P * P) / (4 * `M_PI * 2 * `ub * P * 10000 * abs(-Id - IcAP));
                        duration = durationstatic;
                        if (duration <= ($abstime - AP_Pt)) begin
                            ix = 0.0;
                        end else begin
                            ix = -1.0;
                        end
                    end else begin
                        tau = tau0 * exp(Em * (1 - abs(Id / IcAP)) / (`Kb * temp * 40 * `M_PI));

                        if (Vc > brown_threshold) begin
                            if (Vc < 0.8 * IcAP * Rap) begin
                                duration = tau;
                                if (duration <= ($abstime - NAP_Pt)) begin
                                    ix = 0.0;
                                end else begin
                                    ix = -1.0;
                                end
                            end
                        end
                    end
                end
            end

            I(Ttrans) <+ transition(ix, 0, 1e-12, 1e-12);
            I(T1, T2) <+ Id;
            V(Duration) <+ duration;
        end

        if (Temp_var == 1) begin
            V(n1) <+ (V(T1, T2) * V(T1, T2)) / (2 * R * surface * lam / (thick_s - toxreal));
            I(n1, n2) <+ V(n1, n2) / resistor;
            I(n2) <+ capacitor * (ddt(V(n2)));
            V(Temp) <+ V(n2) + temp_init;
        end else begin
            V(Temp) <+ temp_init;
        end
    end
endmodule
