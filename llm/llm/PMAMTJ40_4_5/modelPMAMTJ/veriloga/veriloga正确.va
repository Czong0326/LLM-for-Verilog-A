/* Copyright @ 2018 Fert Beijing Institute, BDBC and School of Electronic and Information Engineering, Beihang Univeristy, Beijing 100191, China
The terms under which the software and associated documentation (the Software) is provided are as the following:
The Software is provided "as is", without warranty of any kind, express or implied, including but not limited to the warranties of merchantability, fitness for a particular purpose and noninfringement. In no event shall the authors or copyright holders be liable for any claim, damages or other liability, whether in an action of contract, tort or otherwise, arising from, out of or in connection with the Software or the use or other dealings in the Software.
The authors or copyright holders grants, free of charge, to any users the right to modify, copy, and redistribute the Software, both within the user's organization and externally, subject to the following restrictions:
1. The users agree not to charge for the code itself but may charge for additions, extensions, or support.
2. In any product based on the Software, the users agree to acknowledge the Research Group that developed the software. This acknowledgment shall appear in the product documentation.
3. The users agree to reproduce any copyright notice which appears on the software on any copy or modification of such made available to others.
Agreed to by
You WANG, Yue Zhang, Weisheng Zhao, Lirida Alves de Barros Naviner, Hao Cai and Jaques-Olivier Klein

//Title: Compact model of Perpendicular Magnetic Anistropy (PMA) MTJ based on Spin transfer torque mechanism
//Version: Beta.4.5
//Date:7 March 2018
//Language: VerilogA
/*-------------------------------------------

In this model, it takes into account the static, dynamic and stochastic behavoirs of PMA MTJ nanopillar(without using Pwidth)

1.MTJ resistance calculation based on brinkman model
2.TMR dependence on the bias voltage
3.Spin polarity calculation model for magnetic tunnel junction
4.Critical current calculation
5.Dynamic model (>critical current, also sun's model)
6.Stochastic model
7.Resistance variation
8.Temperature evaluation

The parameters are from the prototypes of Univ. Tohuku

---------------------------------------------*/
`resetall
`include "constants.vams"
`include "disciplines.vams"
`define explimit 85.0
`define exp(x) exp(min(max((x),-`explimit),`explimit))
`define sqrt(x) pow( (x), 0.5)

//Shape definition
`define rec 1
`define ellip 2
`define circle 3

/*-------------------------------------------
Electrical Constants
---------------------------------------------*/

/*----------Elementary Charge---------------*/
`define e 1.6e-19
/*----------Bohr Magnetron Costant----------*/
`define ub 9.27e-28
/*----------Boltzmann Constant------------- */
`define Kb 1.38e-23
/*----------Electron Mass------------- */
`define m 9.10e-31
/*----------Euler's constant---------------*/
`define C 0.577

module Model(T1,T2,Ttrans,Temp,Duration);
inout Duration;
electrical Duration;
inout T1, T2;
electrical T1, T2;
electrical n1,n2;    //virtual terminals of RC circuit for time modelisation for temperature

/*----------Ttrans=store the state of the MTJ with time influence, non-volatile way------------- */
/*----------Temp=store the temperature------------- */
inout Ttrans,Temp;
electrical Ttrans,Temp;

/*------------------------------------------
MTJ Technology Parameters
(Corresponds to the HITACHI MTJ Process)
-------------------------------------------*/

/*----------Gilbert Damping Coefficient---------------*/
parameter real  alpha=0.027;
/*----------GyroMagnetic Constant in Hz/Oe---------------*/
parameter real  gamma=1.76e7;
/*----------Electron Polarization Percentage % ---------------*/
parameter real  P=0.52;
/*----------Out of plane Magnetic Anisotropy in Oersteds---------------*/
parameter real  Hk=1433;
/*----------Saturation Field in the Free Layer in Oersteds---------------*/
parameter real  Ms=15800;
/*----------The Energy Barrier Height for MgO in electron-volt---------------*/
parameter real  PhiBas=0.4;
/*----------Voltage bias when the TMR(real) is 1/2TMR(0) in Volt---------------*/
parameter real  Vh=0.5;		//experimental value with MgO barrier

/*------------------------------------------
Device Parameters
(Corresponds to the HITACHI 240 x 80 MTJ)
-------------------------------------------*/
/*----------Height of the Free Layer  in nm---------------*/
parameter real  tsl=1.3e-9 from[0.7e-9:3.0e-9];
/*----------Length in nm---------------*/
parameter real  a=40e-9;
/*----------Width in nm---------------*/
parameter real  b=40e-9;
/*----------Radius in nm---------------*/
parameter real  r=20e-9;
/*----------Height of the Oxide Barrier in nm---------------*/
parameter real  tox=8.5e-10 from[8e-10:15e-10];
/*----------TMR(0) with Zero Volt Bias Voltage ---------------*/
parameter real  TMR=0.7;

/*----------Shape of MTJ---------------*/
parameter real 	SHAPE=2  from[1:3];  //SQUARE

/*----------Neel-Brown model parameter ---------------*/
parameter real 	tau0=8.7e-10;	//experiental value, prototype Hitachi 2007m with CoFe layer

/*----------Error probability Ps=1-Pr(t) ----------------*/
parameter real	Ps=0.999999;

/*----------Threshold for Neel-Brown model----------------*/
parameter real brown_threshold=0.0;

/*----------MTJ State Parameters----------------*/
/*----------Initial state of the MTJ, 0 = parallele, 1 = anti-parallele----*/
parameter integer 	PAP=1 from[0:1];
/*----------Room temperature in Kelvin----------------*/
parameter real 		T= 300;//$random % 50 +323;

/*----------Resistance area product in ohmum2----------------*/
parameter real 		RA=5 from[5:15];

/*----------Parameters of RC circuit for time modelisation for temperature---------------*/
/*----------Heat capacity per unit volume in J/m3*K----------------*/
parameter real 		Cv= 2.74e6  from[2.735e6:2.7805e6];
/*----------Thermal conductivity of the thermal barrier(MgO) in W/m*K----------------*/
parameter real 		lam= 84.897 from [84.8912:84.9449];//

/*----------Total thickness of MTJ nanopillar in nm----------------*/
parameter real 		thick_s= 3.355e-8;//
/*----------RC circuit for time modelisation for temperature---------------*/
parameter real resistor=100e6; //R=100M
parameter real coeff_tau=12; //Coefficient to increase tau_th

real capacitor;   //virtual capacitor
real tau_th;        //characteristic heating/cooling time
real temp;    //real temperature of MTJ
real temp_init;   //temperature initialised
real R;		//resistance of MTJ

parameter integer STO=0 from[0:2];         //choice of stochastic dynamic, 0 no stochastic, 1 random exponential distribution,2 random gauss distribution

parameter integer RV=0 from[0:2];          //choice of stochastic static intrinsically, 0 no stochastic, 1 random uniform distribution,2 random gauss distribution

parameter integer Temp_var=0 from[0:1];     //choice of time modelisation for temperature

parameter real DEV_tox=0.03;        //choice of standard deviation of stochastic static gauss distribution for tox when RV=2
parameter real DEV_tsl=0.03;        //choice of standard deviation of stochastic static gauss distribution for tsl when RV=2
parameter real DEV_TMR=0.03;        //choice of standard deviation of stochastic static gauss distribution for TMRwhen RV=2

parameter real STO_dev=0.03;        //choice of standard deviation of stochastic dynamic gauss distribution when STO=2

//variables

//Polaristion constant for the two states of STT-MTJ
real PolaP; 	//Polarization state parallel of STT-MTJ
real PolaAP; 	//Polarization state anti-parallel of STT-MTJ

real surface;	//Surface of MTJ

//Critical current density for the two states of STT-MTJ
real gp; 	//Critical current density for P state
real gap;	//Critical current density for AP state

real Em,EE; 	//Variable of the Slonczewski model

//TMR real value for the two states of STT-MTJ
real TMRR;	//TMR real value for P state
real TMRRT;	//TMR real value for AP state

//Resistance of MTJ
real Ro;	//Resistance of MTJ when bias voltage = 0V
real Rap;	//Resistance value for AP state
real Rp;	//Resistance value for P state

//Voltage of MTJ
real Vb;	//V(T1,T2)
real Vc;	//V(T2,T1)

real Id;	//Current of MTJ

//critial current for the two states of STT-MTJ
real IcAP; 	//Critial current for AP state
real IcP;	//Critial current for P state

real ix;	//Current used to store the state of the MTJ

real tau;	//Probability parameter

real FA; //Factor for calculating the resistance based on RA

integer seed;	//Used to initialize the random number generator

//Stochastic effects
real durationstatic,duration;	//time needed to be sure that the switching is effected

real toxreal;   //real thickness of oxide layer
real tslreal;	//real thickness of free layer
real TMRreal;	//real TMR
(*cds_inherited_parameter*)parameter real seedin = 0;  //generation of a real random value of seed for random distribution function modified 20140223

real P_APt;
real AP_Pt;
real NP_APt,NAP_Pt;
analog begin

	if (SHAPE==1)
		begin
		surface=a*b;	//SQUARE
		end
		else if (SHAPE==2)
		begin
		surface=`M_PI*a*b/4;	//ELLIPSE
		end
		else
		begin
		surface=r*r;    //ROUND
	end

	Vc=V(T2,T1);	//potential between T2 and T1
	Vb=V(T1,T2);	//potential between T2 and T1
//initial conditions
@(initial_step)
begin

	seed=1000000000*seedin;	//initialization of seed modified 20140516

	FA=3322.53/RA;	//initialization of resistance factor according to RA product

	if (RV==1)
		begin
			//real thinkness of oxide layer, free layer and real TMR considering the random distribution(uniform distribution)
			toxreal=$rdist_uniform(seed,(tox-tox*DEV_tox),(tox+tox*DEV_tox));
			tslreal=$rdist_uniform(seed,(tsl-tsl*DEV_tsl),(tsl+tsl*DEV_tsl));
			TMRreal=$rdist_uniform(seed,(TMR-TMR*DEV_TMR),(TMR+TMR*DEV_TMR));
		end
	else if (RV==2)
		begin
			//real thinkness of oxide layer, free layer and real TMR considering the random distribution(gauss distribution)
			toxreal=abs($rdist_normal(seed,tox,tox*DEV_tox/3));
			tslreal=abs($rdist_normal(seed,tsl,tsl*DEV_tsl/3));
			TMRreal=abs($rdist_normal(seed,TMR,TMR*DEV_TMR/3));

		end
	else
		begin
			toxreal=tox;
			tslreal=tsl;
			TMRreal=TMR;
		end
	temp=T;
        temp_init=T;

        tau_th= Cv*thick_s / (lam/thick_s);

        capacitor=coeff_tau*tau_th/resistor;	//tau_th=resistor*capacitor

	Ro=(toxreal*1.0e10/(FA*`sqrt(PhiBas)*surface*1.0e12))*exp(1.025*toxreal*1.0e10*`sqrt(PhiBas));	//resistance

	Em=Ms*tslreal*surface*Hk/2;
	duration=0.0;
	P_APt=1000000000;
	AP_Pt=1000000000;
        NP_APt=1000000000;
	NAP_Pt=1000000000;
        if(analysis("dc"))
	    begin
	      //States inititialisation
	      ix=PAP;
	    end
        else
	    begin
	      ix=-PAP;
	    end

       // I(T1,T2)<+ Id;	//Actualisation of the current of MTJ with the value calculated

end

if(Temp_var==0)
   begin
      temp=temp_init;        //temperature constant
   end
else
   begin
      temp=V(Temp);          //time modelisation for temperature
   end

EE=Em/(`Kb*temp*40*`M_PI);  //result of E/kbT

 /*----calculation of real current------*/
 TMRR=TMRreal/(1+Vb*Vb/(Vh*Vh));	//Parallel resistance
 Rp=Ro;
 Rap=Rp*(1+TMRR);
  if(ix==0)
      begin
         R=Rp;
      end
  else
      begin
         R=Rap;
      end
  Id=Vb/R;

 /*----calculation of rcritical current------*/

 PolaP=`sqrt(TMRreal*(TMRreal+2))/(2*(TMRreal+1));  	//Polarization state parallel
 gp=alpha*gamma*`e*Ms*tslreal*Hk/(40*`M_PI*(`ub*PolaP)); 	//Critical current density
 IcP=gp*surface;		// Critical current for P state

 PolaAP=`sqrt(TMRreal*(TMRreal+2))/(2*(TMRreal+1));  	//Polarization state anti parallel
 gap=alpha*gamma*`e*Ms*tslreal*Hk/(40*`M_PI*(`ub*PolaAP));  	//Critical current density
 IcAP=gap*surface; 	// Critical current for AP state

      /*------Counter of time when real current is higher than critical current */
           @(above(Id-IcP,+1))
           begin
	         P_APt = $abstime;
		 NP_APt=1000000000;
           end

           @(above(-Id-IcAP,+1))
           begin
	         AP_Pt = $abstime;
		 NAP_Pt=1000000000;
           end
           @(above(Vb-brown_threshold,+1))
           begin
	         NP_APt = $abstime;
		 AP_Pt=1000000000;
		 NAP_Pt=1000000000;
           end

           @(above(Vc-brown_threshold,+1))
           begin
	         NAP_Pt = $abstime;
		 P_APt=1000000000;
		 NP_APt=1000000000;
           end

if(analysis("dc"))   //dc analysis

	begin
		if(ix==0)	//Case which the magnetizations of the two layers are parallel
			begin
				if(Vb>=(IcP*Rp))
					begin
						ix=1.0;

					end
			end
		else
			begin
				if(Vc>=(IcAP*Rap))
					begin
						ix=0.0;
					end
			end

                V(Ttrans)<+ix;
                I(T1,T2)<+Id;	//Actualisation of the current of MTJ with the value calculated
        end
else                        //transient analysis
	begin

        if(STO==1||STO==2)    //considering the stochastic behaviors
          begin

	    if(ix==0)	//Case which the magnetizations of the two layers are parallel
		begin
		     if(Vb>=IcP*Rp)
				begin	//Current higher than critical current,STT-MTJ dynamic behavior : Sun model
					//Time needed to be sure that the switching is effected
				     durationstatic=(`C+ln(`M_PI*`M_PI*(Em/(`Kb*temp*40*`M_PI))/4))*`e*1000*Ms*surface*tslreal*(1+P*P)/(4*`M_PI*2*`ub*P*10000*abs(Id-IcP));

				     if(STO==1)
					begin
					     duration=abs($rdist_exponential(seed, durationstatic));	//stochastic effect(exponential distribution)
					end
				     else if(STO==2)
					begin

					     duration=abs($rdist_normal(seed,durationstatic,durationstatic*STO_dev/3));	//stochastic effect(gauss distribution)
					end
				     else
					begin
					     duration=durationstatic;
					end

				     if(duration<=($abstime-P_APt))
					begin	//Switching of the free layer always occurs
						ix=-1.0;   //change the current state of MTJ

					end
				     else
					begin
						ix=0.0;
					end
				 end

			else
				 begin	//Current smaller than critical current

				      ix=0.0;	//save the current state of MTJ,STT-MTJ dynamic behavior : Neel-Brown model
				      tau=tau0*exp(Em*(1-abs(Id/IcP))/(`Kb*temp*40*`M_PI));

				      if(Vb>brown_threshold)
					 begin
					      if (Vb<0.8*IcP*Rp)
						   begin

							if(STO==1)
							       begin
								    duration=abs($rdist_exponential(seed, tau));	//stochastic effect
							       end
							else if(STO==2)
					                       begin

					                            duration=abs($rdist_normal(seed,tau,tau*STO_dev/3));	//stochastic effect(gauss distribution)
					                       end
							else
							       begin
								    duration=tau;
							       end
                                                        if (($abstime-NP_APt) >= duration)
					  		       begin
								     ix=-1.0;   //change the current state of MTJ

							       end
							else
							       begin
								     ix=0.0;
							       end

					            end
				           end

			          end

	    end  //end of parallel state

	 else   	//Case which the magnetizations of the two layers are antiparallel
            begin
	      if(Vc>=(IcAP*Rap))
		begin	//Current higher than critical current,STT-MTJ dynamic behavior : Sun model

			durationstatic=(`C+ln(`M_PI*`M_PI*(Em/(`Kb*temp*40*`M_PI))/4))*`e*1000*Ms*surface*tslreal*(1+P*P)/(4*`M_PI*2*`ub*P*10000*abs(-Id-IcAP));
			//time needed to be sure that the switching is effected
			if(STO==1)
				begin
					duration=abs($rdist_exponential(seed, durationstatic));	//stochastic effect
				end
			else if(STO==2)
				 begin
					duration=abs($rdist_normal(seed,durationstatic,durationstatic*STO_dev/3.0));	//stochastic effect(gauss distribution)
			         end
			else
				 begin
					duration=durationstatic;
				 end
			if(duration<=($abstime-AP_Pt))
				 begin	//Switching of the free layer always occurs
					ix=0.0;   //change the current state of MTJ

	                         end
			else
				 begin
					ix=-1.0;
				 end
		end
	      else
		begin	//Current smaller than critical current,STT-MTJ dynamic behavior : Neel-Brown model
			tau=tau0*exp(Em*(1-abs(Id/IcAP))/(`Kb*temp*40*`M_PI));

			if(Vc>brown_threshold)
			     begin
				  if (Vc<0.8*IcAP*Rap)
					begin
					     if(STO==1)
						   begin
							duration=abs($rdist_exponential(seed, tau));	//stochastic effect
                                                   end
					     else if(STO==2)
					           begin
							duration=abs($rdist_normal(seed,tau,tau*STO_dev/3));	//stochastic effect(gauss distribution)
					           end
					     else
						   begin
							duration=tau;
						   end
					     if (duration<=($abstime-NAP_Pt))
					  	   begin
							ix=0.0;   //change the current state of MTJ

                                                   end
					     else
						   begin
						        ix=-1.0;
						   end
					end

			      end
		 end

	   end   // end of antiparallel state

        end    //end of module with consideration of stochastic behaviors

     else                          //without consideration of stochastic behaviors
            begin

               if(ix==0)	//Case which the magnetizations of the two layers are parallel
		    begin
			if(Vb>=IcP*Rp)	//Current higher than critical current,	STT-MTJ dynamic behavior : Sun model
				begin
					//Time needed to be sure that the switching is effected
				      durationstatic=(`C+ln(`M_PI*`M_PI*(Em/(`Kb*temp*40*`M_PI))/4))*`e*1000*Ms*surface*tslreal*(1+P*P)/(4*`M_PI*2*`ub*P*10000*abs(Id-IcP));
				      duration=durationstatic;
				      if(duration<=($abstime-P_APt))
					   begin	//Switching of the free layer always occurs
						ix=-1.0;   //change the current state of MTJ

					   end
				      else
					   begin
						ix=0.0;
					   end

				 end
			 else
				 begin	//Current smaller than critical current
				       tau=tau0*exp(Em*(1-abs(Id/IcP))/(`Kb*temp*40*`M_PI));

				       if(Vb>brown_threshold)
					   begin
						if (Vb<0.8*IcP*Rp)
							begin
								duration=tau;
							        if (($abstime-NP_APt) >= duration)
					  			     begin
									 ix=-1.0;   //change the current state of MTJ

								     end
								else
								     begin
									 ix=0.0;
								end
							end
					   end
				  end
	              end

	        else   	//Case which the magnetizations of the two layers are antiparallel

		      begin
			    if(Vc>=(IcAP*Rap))
				   begin	//Current higher than critical current,STT-MTJ dynamic behavior : Sun model
                                          durationstatic=(`C+ln(`M_PI*`M_PI*(Em/(`Kb*temp*40*`M_PI))/4))*`e*1000*Ms*surface*tslreal*(1+P*P)/(4*`M_PI*2*`ub*P*10000*abs(-Id-IcAP));
					  duration=durationstatic;  //time needed to be sure that the switching is effected
					  if(duration<=($abstime-AP_Pt))
						begin	//Switching of the free layer always occurs
							ix=0.0;   //change the current state of MTJ
						end
					  else
						begin
							ix=-1.0;
						end
				    end
			     else
				    begin	//Current smaller than critical current,STT-MTJ dynamic behavior : Neel-Brown model
					   tau=tau0*exp(Em*(1-abs(Id/IcAP))/(`Kb*temp*40*`M_PI));
			                   if(Vc>brown_threshold)
					        begin
						    if (Vc<0.8*IcAP*Rap)
							begin
								  duration=tau;
								  if (duration<=($abstime-NAP_Pt))
					  				begin
										ix=0.0;   //change the current state of MTJ
									end
										else
									begin
										ix=-1.0;
									end
                                                        end
			            end
			end

	       end

           end

	   I(Ttrans)<+ transition(ix,0,1e-12,1e-12); //Ttrans has the same function than x but it includes the time effects

           I(T1,T2)<+Id;	//Actualisation of the current of MTJ with the value calculated

           V(Duration) <+ duration;

      end    //end of transient analysis
           if(Temp_var==1)
                begin
                     V(n1) <+ ( V(T1,T2)*V(T1,T2) )/ ( 2*R*surface*lam/(thick_s-toxreal));   //Definition of the maximum incrase of temperature

                     I(n1,n2) <+ V(n1,n2) / resistor;	// RC circuit definition,RC circuit parallel
                     I(n2) <+ capacitor * (ddt(V(n2)));

                     V(Temp) <+  V(n2) + temp_init;
                end
           else
               begin
                     V(Temp) <+  temp_init;

               end

   end  //end of analog begin

endmodule
